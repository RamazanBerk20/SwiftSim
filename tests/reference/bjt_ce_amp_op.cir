* Common-emitter amplifier, operating point
.include bjt_ce_amp.inc
.op
.end
