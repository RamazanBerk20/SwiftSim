* RC low-pass: resistor noise filtered by C integrates to sqrt(kT/C) over a wide band
V1 in 0 DC 0 AC 1
R1 in out 10k
C1 out 0 1n
.noise V(out) V1 dec 20 1 10g
.end
