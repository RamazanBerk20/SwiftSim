* VDMOS low-side switch, DC transfer (gate swept)
.include models.inc
VDD vdd 0 12
RL vdd d 1
VG g 0 0
M1 d g 0 MPWR
.dc VG 0 6 0.01
.end
