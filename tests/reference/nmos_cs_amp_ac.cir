* Level-1 NMOS common-source amplifier, Miller effect from CGDO, AC
.include models.inc
VDD vdd 0 5
VIN in 0 DC 0 AC 1
Rsig in a 10k
CIN a g 1u
R1 vdd g 300k
R2 g 0 100k
RD vdd d 10k
M1 d g 0 0 NM W=200u L=2u
CL d 0 1p
.ac dec 20 10 10g
.end
